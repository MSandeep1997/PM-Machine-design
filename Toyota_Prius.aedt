# Ansys Electronics Desktop project, version 2021.1
materials:
  M43_29G: permeability{HUnit=A_per_meter BUnit=tesla curve (0, 0) (159, 0.9) (238.7, 1.05) (318, 1.15) (461, 1.25) (636, 1.325) (795.7, 1.375) (1192, 1.425) (1872, 1.475) (2952, 1.525) (4417, 1.575) (6270.5, 1.63) (8245.5, 1.68) (10120.6, 1.719) (13181, 1.7705) (16395.6, 1.8165) (19746.7, 1.86) (24946.7, 1.92) (34113.4, 1.975) (58113.4, 2.025) (96113.4, 2.075)} conductivity=2500000 core_loss_type="Electrical Steel" core_loss_kh=222.8 core_loss_kc=0.521 mass_density=7700
  Magnet permanent Ferrite Y30BH (YBM-2B): permeability{HUnit=A_per_meter BUnit=tesla curve (-244580, 0) (-242618, 0.0363807) (-236500, 0.0667111) (-226128, 0.0931811) (-211541, 0.114587) (-194389, 0.138404) (-176381, 0.163199) (-159533, 0.184822) (-140377, 0.210897) (-122373, 0.23505) (-105232, 0.25724) (-88943, 0.278993) (-70187.4, 0.304631) (-54645.7, 0.325617) (-37634.8, 0.348019) (-20349.1, 0.370146) (0, 0.396357)} conductivity=0.01 magnetic_coercivity{Magnitude=-244580A_per_meter DirComp1=1 DirComp2=0 DirComp3=0}
  copper: permeability=0.999991 conductivity=58000000
  vacuum: permittivity=1

design dynamic_analysis_M43_29G_iron (Maxwell 2D, Transient, XY geometry, model units mm)
options: ComputeTransientInductance ModelDepth=83.82mm
geometry:
  Stator [M43_29G] = user_primitive(RMxprt/SlotCore.dll, DiaGap=161.9mm, DiaYoke=269.24mm, Length=0mm, Skew=0deg, Slots=48, SlotType=2, Hs0=1.03mm, Hs01=0mm, Hs1=0mm, Hs2=29.5mm, Bs0=1.93mm, Bs1=5mm, Bs2=8mm, Rs=5mm, FilletType=0, HalfSlot=0, SegAngle=0deg, LenRegion=200mm, InfoCore=0)
  Rotor [M43_29G] = user_primitive(RMxprt/IPMCore.dll, DiaGap=160.4mm, DiaYoke=110.64mm, Length=0mm, Poles=8, PoleType=5, D1=157.44mm, O1=3mm, O2=7.28mm, B1=4.7mm, Rib=14mm, HRib=3mm, DminMag=4.5mm, ThickMag=6.48mm, WidthMag=32mm, LenRegion=200mm, InfoCore=0)
  PM1 [Magnet permanent Ferrite Y30BH (YBM-2B), oriented by PM1_CS] = user_primitive(RMxprt/IPMCore.dll, DiaGap=160.4mm, DiaYoke=110.64mm, Length=0mm, Poles=8, PoleType=5, D1=157.44mm, O1=3mm, O2=7.28mm, B1=4.7mm, Rib=14mm, HRib=3mm, DminMag=4.5mm, ThickMag=6.48mm, WidthMag=32mm, LenRegion=200mm, InfoCore=1)
  PhaseA1 [copper] = user_primitive(RMxprt/LapCoil.dll, DiaGap=161.9mm, DiaYoke=269.24mm, Length=0mm, Skew=0deg, Slots=48, SlotType=2, Hs0=1.28mm, Hs1=0.1mm, Hs2=29.7mm, Bs0=2.11mm, Bs1=3.14mm, Bs2=5.65mm, Rs=2.5mm, FilletType=0, Layers=1, CoilPitch=5, EndExt=5mm, SpanExt=18mm, BendAngle=0deg, SegAngle=10deg, LenRegion=200mm, InfoCoil=1)
  PhaseA1.rotate(axis=Z, angle=7.5deg)
  PhaseC1, PhaseB1 [copper] = PhaseA1.duplicate_around_axis(axis=Z, angle=15deg, total=3)
  PhaseA2 [copper] = PhaseA1.duplicate_around_axis(axis=Z, angle=45deg, total=8)  # copies kept: 7
  PhaseB2 [copper] = PhaseB1.duplicate_around_axis(axis=Z, angle=45deg, total=8)  # copies kept: 7
  PhaseC2 [copper] = PhaseC1.duplicate_around_axis(axis=Z, angle=45deg, total=8)  # copies kept: 7
  [Stator, Rotor, PM1, PhaseA1, PhaseC1, PhaseB1, PhaseA2, PhaseB2, PhaseC2].split(plane=ZX, keep=PositiveOnly)
  [Stator, Rotor, PM1, PhaseA1, PhaseC1, PhaseB1, PhaseA2, PhaseB2, PhaseC2].rotate(axis=Z, angle=-45deg)
  [Stator, Rotor, PM1, PhaseA1, PhaseC1, PhaseB1, PhaseA2, PhaseB2, PhaseC2].split(plane=ZX, keep=NegativeOnly)
  [Stator, Rotor, PM1, PhaseA1, PhaseC1, PhaseB1, PhaseA2, PhaseB2, PhaseC2].rotate(axis=Z, angle=45deg)
  Region [vacuum] = polyline((0mm, 0mm, 0mm) (200mm, 0mm, 0mm))
  Region.sweep_around_axis(axis=Z, angle=45deg, segments=5)
  PM2 [Magnet permanent Ferrite Y30BH (YBM-2B), oriented by PM2_CS] = PM1.separate_bodies()
  coordinate_system PM1_CS = face of PM1: Origin=PM1.vertex(28 of 64) FaceID=PM1.face(7 of 16) AxisPosn=PM1.vertex(25 of 64) WhichAxis=X ZRotationAngle=0 XOffset=0 YOffset=0
  coordinate_system PM2_CS = face of PM2: Origin=PM1.vertex(62 of 64) FaceID=PM1.face(16 of 16) AxisPosn=PM1.vertex(63 of 64) WhichAxis=X ZRotationAngle=0 XOffset=0 YOffset=0
  Band [vacuum] = polyline((0mm, 0mm, 0mm) (80.575mm, 0mm, 0mm))
  Band.sweep_around_axis(axis=Z, angle=45deg, segments=45)
  Bandin [vacuum] = polyline((0mm, 0mm, 0mm) (80.4mm, 0mm, 0mm))
  Bandin.sweep_around_axis(axis=Z, angle=45deg, segments=45)
  Rotor2 [M43_29G] = polyline((78.72mm, 0mm, 0mm) (80.2mm, 0mm, 0mm))
  Rotor2.sweep_around_axis(axis=Z, angle=45deg)
  Rotor3 [M43_29G] = polyline((78.72mm, 0mm, 0mm) (79.46mm, 0mm, 0mm))
  Rotor3.sweep_around_axis(axis=Z, angle=45deg)
motion:
  MotionSetup1: Band Move_Type=Rotate Coordinate_System=Global Axis=Z Is_Positive=true InitPos=30deg Angular_Velocity=3000rpm Objects=Band
  Moving1: Moving Objects=[Rotor, PM1, PM2, Bandin, Rotor2, Rotor3]
boundaries and excitations:
  Master1: Independent Edges=Region.edge(1 of 1)
  Slave1: Dependent Edges=Region.edge(#2437) ReverseU Independent=Master1 SameAsMaster=false
  Zero_Flux: Vector Potential Edges=Region.edge(#2431, #2432, #2433, #2434, #2435, #2436) Value=0
  PhaseA1: Coil Objects=PhaseA1 Conductor_number=9 Winding=PhaseA PolarityType=Positive
  PhaseA2: Coil Objects=PhaseA2 Conductor_number=9 Winding=PhaseA PolarityType=Positive
  PhaseB1: Coil Objects=PhaseB1 Conductor_number=9 Winding=PhaseB PolarityType=Positive
  PhaseB2: Coil Objects=PhaseB2 Conductor_number=9 Winding=PhaseB PolarityType=Positive
  PhaseC1: Coil Objects=PhaseC1 Conductor_number=9 Winding=PhaseC PolarityType=Negative
  PhaseC2: Coil Objects=PhaseC2 Conductor_number=9 Winding=PhaseC PolarityType=Negative
  PhaseA: Winding Group Type=Current IsSolid=false Current=250*sin(1256.637*Time+0.35) ParallelBranchesNum=1
  PhaseB: Winding Group Type=Current IsSolid=false Current=250*sin(1256.637*Time-(2*pi/3)+0.35) ParallelBranchesNum=1
  PhaseC: Winding Group Type=Current IsSolid=false Current=250*sin(1256.637*Time+(2*pi/3)+0.35) ParallelBranchesNum=1
mesh:
  Coils: LengthBased RefineInside Objects=[PhaseA1, PhaseA2, PhaseB1, PhaseB2, PhaseC1, PhaseC2] MaxLength=4mm
  PMs: LengthBased RefineInside Objects=[PM1, PM2] MaxLength=3mm
  Rotor: LengthBased RefineInside Objects=Rotor MaxLength=4mm
  Stator: LengthBased RefineInside Objects=Stator MaxLength=4mm
  initial mesh: MeshMethod=AnsoftTAU
setups:
  Setup1: Transient NonlinearSolverResidual=1e-06 StopTime=15ms TimeStep=250us SaveFieldsType=Custom SweepRanges{10000000ns to 15ms step 250us} NumberSolveSteps=1 RangeStart=0s RangeEnd=0.1s InitialTimeStep=0.002s MinTimeStep=0.001s MaxTimeStep=0.003s TimeStepErrTolerance=0.0001
reports:
  Torque: Moving1.LoadTorque, Moving1.Torque vs Time on Setup1 : Transient
  Winding Plot 1: FluxLinkage(PhaseA), FluxLinkage(PhaseB), FluxLinkage(PhaseC) vs Time on Setup1 : Transient
  Winding Plot 2: InducedVoltage(PhaseA), InducedVoltage(PhaseB), InducedVoltage(PhaseC) vs Time on Setup1 : Transient
  Winding Plot 3: InputCurrent(PhaseA), InputCurrent(PhaseB), InputCurrent(PhaseC) vs Time on Setup1 : Transient
   Plot 2: FluxLinkage(PhaseA)/InputCurrent(PhaseB) vs Time on Setup1 : Transient
   Plot 3: FluxLinkage(PhaseA)/InputCurrent(PhaseA) vs Time on Setup1 : Transient
   Plot 4: FluxLinkage(PhaseA)/InputCurrent(PhaseC) vs Time on Setup1 : Transient
  Winding Plot 4: L(PhaseA,PhaseA), L(PhaseA,PhaseB), L(PhaseA,PhaseC), L(PhaseB,PhaseA), L(PhaseB,PhaseB), L(PhaseB,PhaseC), L(PhaseC,PhaseA), L(PhaseC,PhaseB), L(PhaseC,PhaseC) vs Time on Setup1 : Transient
  Torque_speed: Moving1.Torque vs Moving1.Speed on Setup1 : Transient
